** sch_path: /home/la_hk/ktu-proto-lab/sg13g2/sar_adc/xschem/blocks/bandgap/1.2v_bandgap_tb.sch
**.subckt 1.2v_bandgap_tb
V1 VDDH 0 3.3
x1 VDDH Out 0 1.2v_bandgap
**** begin user architecture code

.lib /eda/IHP-Open-PDK/ihp-sg13g2/libs.tech/ngspice/models/cornerMOShv.lib mos_tt
.lib /eda/IHP-Open-PDK/ihp-sg13g2/libs.tech/ngspice/models/cornerRES.lib res_typ
.lib /eda/IHP-Open-PDK/ihp-sg13g2/libs.tech/ngspice/models/cornerCAP.lib cap_typ
.lib /eda/IHP-Open-PDK/ihp-sg13g2/libs.tech/ngspice/models/cornerHBT.lib hbt_typ

* Gear integration: suppresses trapezoidal ringing that blocks
* transient-op convergence at cold corner (-40C). Required for full-range sim.
.options method=gear

.ic v(VDDH)=3.3 v(x1.net1)=0 v(x1.v_c1)=0 v(x1.net3)=0

.control

save all
set temp=27

op
echo === OP node voltages (27C) ===
print v(x1.Inp) v(x1.Inn) v(x1.net1) v(x1.net2) v(x1.net_1) v(Out)
* Startup branch currents (Vmeas are inside x1, so use hierarchical name):
print i(v.x1.vmeas1) i(v.x1.vmeas2) i(v.x1.vmeas3)

dc temp -40 125 1

* Correct node map for THIS netlist:
*  Q1 emitter = net1 (8x)      Q2 emitter = Inn (1x)     Q3 emitter = net2
*  PTAT resistor XR1 is between net1 and Inp  ->  dVbe = Inp - net1
*  net3/net4 = startup PMOS sources (~3.3V), NOT diode nodes

let vbe    = x1.Inn                 $ CTAT reference (Q2 Vbe)
let vdvbe  = x1.Inp - x1.net1       $ PTAT voltage across XR1 (13k)
let veq    = out                    $ bandgap output

* Vbe CTAT stats
let vbe_max = vecmax(vbe)
let vbe_min = vecmin(vbe)
let vbe_nom = mean(vbe)
let tc_vbe  = ((vbe_max - vbe_min) / vbe_nom) * 1e6 / 165

* Delta_Vbe PTAT stats
let vr_max = vecmax(vdvbe)
let vr_min = vecmin(vdvbe)
let vr_nom = mean(vdvbe)
let tc_vr  = ((vr_max - vr_min) / vr_nom) * 1e6 / 165

* PTAT current  (XR1 = 100u/2u rppd ~ 13 kOhm)
let i_ptat    = vdvbe / 13e3
let i_ptat_ua = i_ptat * 1e6

* Bandgap output stats
let veq_max = vecmax(veq)
let veq_min = vecmin(veq)
let veq_nom = mean(veq)
let tc_eq   = ((veq_max - veq_min) / veq_nom) * 1e6 / 165

echo === Vbe CTAT (Inn = Q2 emitter) ===
print vbe_max vbe_min vbe_nom tc_vbe

echo === Delta_Vbe PTAT (Inp - net1, across XR1) ===
print vr_max vr_min vr_nom tc_vr

echo === I_PTAT uA ===
print vecmax(i_ptat_ua) vecmin(i_ptat_ua) mean(i_ptat_ua)

echo === Bandgap Output (Out) ===
print veq_max veq_min veq_nom tc_eq

echo === Q3 emitter (net2) ===
print vecmax(x1.net2) vecmin(x1.net2) mean(x1.net2)

let veq_center = (veq_max + veq_min) / 2
let tc_eq_pp = (veq_max - veq_min) / veq_center * 1e6 / 165
echo === TC (peak-to-peak / center) ===
print tc_eq_pp

plot x1.Inn title 'Vbe vs. T (CTAT)'
plot x1.Inp - x1.net1 title 'Delta_Vbe vs. T (PTAT, across XR1)'
plot out title 'Bandgap output vs. T'
plot i_ptat_ua title 'I_PTAT uA vs. T'

* Bandgap startup analysis
tran 50p 300n uic
plot x1.net_1 x1.v_c1 x1.net_3 title 'Startup circuit voltages'
plot out title 'Output voltage at startup'
plot x1.Inp x1.Inn title 'Equilibrium voltages at startup'
plot i(v.x1.Vmeas1) i(v.x1.Vmeas2) i(v.x1.Vmeas3) xlimit 0 20n title 'Startup circuit currents'

.endc

**** end user architecture code
**.ends

* expanding   symbol:  blocks/bandgap/1.2v_bandgap.sym # of pins=3
** sym_path: /home/la_hk/ktu-proto-lab/sg13g2/sar_adc/xschem/blocks/bandgap/1.2v_bandgap.sym
** sch_path: /home/la_hk/ktu-proto-lab/sg13g2/sar_adc/xschem/blocks/bandgap/1.2v_bandgap.sch
.subckt 1.2v_bandgap VDDH Out VSS
*.iopin VSS
*.ipin VDDH
*.opin Out
XM1 Inp net_1 VDDH VDDH sg13_hv_pmos w=4u l=1u ng=1
x1 VDDH Inp Inn net_1 I_bias VSS OTA_1
XM2 Inn net_1 VDDH VDDH sg13_hv_pmos w=4u l=1u ng=1
XR1 net1 Inp VSS rppd w=2e-6 l=100e-6 m=1 b=0
XQ1 VSS VSS net1 pnpMPA a=2e-12 p=6e-06 m=8
XQ2 VSS VSS Inn pnpMPA a=2e-12 p=6e-06
XM3 Out net_1 VDDH VDDH sg13_hv_pmos w=4u l=1u ng=1
XQ3 VSS VSS net2 pnpMPA a=2e-12 p=6e-06
XR2 net2 Out VSS rppd w=2e-6 l=784e-6 m=1 b=0
XM9 I_bias net_1 VDDH VDDH sg13_hv_pmos w=4u l=1u ng=1
XM4 net_3 v_c1 net3 net3 sg13_hv_pmos w=2u l=0.4u ng=1
XM6 v_c1 v_c1 net4 net4 sg13_hv_pmos w=1u l=0.4u ng=1
XM7 net_3 Inp VSS VSS sg13_hv_nmos w=0.3u l=0.45u ng=1
XM8 net5 net_3 VSS VSS sg13_hv_nmos w=5u l=0.45u ng=1 m=2
XC1 v_c1 VSS cap_cmim w=5.0e-6 l=5.0e-6
XM11 VSS VDDH v_c1 VDDH sg13_hv_pmos w=1u l=0.4u ng=1
Vmeas2 VDDH net3 0
.save i(vmeas2)
Vmeas3 net_1 net5 0
.save i(vmeas3)
Vmeas1 VDDH net4 0
.save i(vmeas1)
.ends

* expanding   symbol:  blocks/cascode_ota/OTA_1.sym # of pins=6
** sym_path: /home/la_hk/ktu-proto-lab/sg13g2/sar_adc/xschem/blocks/cascode_ota/OTA_1.sym
** sch_path: /home/la_hk/ktu-proto-lab/sg13g2/sar_adc/xschem/blocks/cascode_ota/OTA_1.sch
.subckt OTA_1 VDDH Inp Inn Out I_bias VSS
*.ipin VDDH
*.iopin VSS
*.ipin I_bias
*.opin Out
*.ipin Inp
*.ipin Inn
XM2 net1 net1 VDDH VDDH sg13_hv_pmos w=10u l=1u ng=1
XM3 net1 I_bias VSS VSS sg13_hv_nmos w=3u l=3u ng=1
XM1 I_bias I_bias VSS VSS sg13_hv_nmos w=3u l=3u ng=1
XM11 net8 I_bias VSS VSS sg13_hv_nmos w=3u l=3u ng=1
XM13 net5 Inp net2 VDDH sg13_hv_pmos w=8u l=1u ng=2
XM14 net6 Inn net2 VDDH sg13_hv_pmos w=8u l=1u ng=2
XM15 net7 net4 VDDH VDDH sg13_hv_pmos w=10u l=1u ng=1
XM20 net3 net4 VDDH VDDH sg13_hv_pmos w=10u l=1u ng=1
XM17 net4 v_net3 net7 VDDH sg13_hv_pmos w=10u l=1u ng=1
XM18 net4 v_net2 net5 VSS sg13_hv_nmos w=10u l=1u ng=1
XM19 net5 v_net1 VSS VSS sg13_hv_nmos w=9u l=1u ng=1
XM22 Out v_net2 net6 VSS sg13_hv_nmos w=10u l=1u ng=1
XM23 net6 v_net1 VSS VSS sg13_hv_nmos w=9u l=1u ng=1
XM12 net2 net8 VDDH VDDH sg13_hv_pmos w=10u l=1u ng=1
XM10 net8 net8 VDDH VDDH sg13_hv_pmos w=10u l=1u ng=1
XM6 v_net1 v_net1 VSS VSS sg13_hv_nmos w=8u l=1u ng=1
XM4 v_net2 net1 VDDH VDDH sg13_hv_pmos w=10u l=1u ng=1
XM5 v_net2 v_net2 v_net1 VSS sg13_hv_nmos w=10u l=1u ng=2
XM7 net9 net9 VDDH VDDH sg13_hv_pmos w=10u l=1u ng=1
XM9 v_net3 I_bias VSS VSS sg13_hv_nmos w=1.9u l=3u ng=1
XM8 v_net3 v_net3 net9 VDDH sg13_hv_pmos w=10u l=1u ng=1
XM21 Out v_net3 net3 VDDH sg13_hv_pmos w=10u l=1u ng=1
.ends

.end
